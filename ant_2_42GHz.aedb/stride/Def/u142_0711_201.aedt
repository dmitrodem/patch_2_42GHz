# Ansys Electronics Desktop project, version 2024.1
materials:
  vacuum: permittivity=1

design u142_0711_201 (HFSS, HFSS Hybrid Terminal Network, model units mm)
options: Calculate_Lossy_Dielectrics
geometry:
  u142_0711_201_1 = component(u142_0711_201, 3D_Component_File_Path=/home/ubuntu/Ansoft/u142_0711_201.a3dcomp, N=32)
  center_pin, outer_shell [pec] = part_of(u142_0711_201_1)
  dielectric, port [vacuum] = part_of(u142_0711_201_1)
boundaries and excitations:
  u142_0711_201_1_1: Wave Port Objects=port WavePortType=Modal NumModes=1 Modes{Mode1{CharImp=Zpi}}
setups:
  AutoSetup1: HfssDriven Frequency=1000000000 MaxDeltaS=0.02 MaximumPasses=6 MinimumPasses=1 MinimumConvergedPasses=1 PercentRefinement=30 BasisOrder=1 PortAccuracy=2 DrivenSolverType="Direct Solver"
  AutoSetup2: HfssDriven Frequency=1000000000 MaxDeltaS=0.02 MaximumPasses=6 MinimumPasses=1 MinimumConvergedPasses=1 PercentRefinement=30 BasisOrder=1 PortAccuracy=2 DrivenSolverType="Direct Solver"
source amplitudes:
  u142_0711_201_1_1:1: 1V 0deg
