# Ansys Electronics Desktop project, version 2024.1
materials:
  air: permittivity=1.0006 permeability=1.0000004
  vacuum: permittivity=1
  pec: conductivity=1e+30
  copper: permeability=0.999991 conductivity=58000000
  ro4003: permittivity=3.38 permeability=1 dielectric_loss_tangent=0.0027
  ro4450f: permittivity=3.52 dielectric_loss_tangent=0.002

design HFSSDesign1 (HFSS, HFSS Hybrid Terminal Network, model units mm)
options: Allow_Material_Override Calculate_Lossy_Dielectrics Save_Adaptive_support_files
variables:
  pad = 45mm
  R0 = 1000000ohm
geometry:
  film, gnd [copper] = imported_body()
  prepreg, prepreg2 [ro4450f] = imported_body()
  signal_low, signal_low_L1, signal_low_L10..signal_low_L13, signal_low_L2..signal_low_L9 [copper] = imported_body()
  signal_low_t_fill [ro4003] = imported_body()
  signal_mid, signal_mid_L1, signal_mid_L10, signal_mid_L11, signal_mid_L12, signal_mid_L2..signal_mid_L9 [copper] = imported_body()
  signal_mid_t_fill, substrate_low, substrate_mid, substrate_mid2 [ro4003] = imported_body()
  via_31, via_34, via_47, via_48, via_49, via_57..via_63 [copper] = imported_body()
  coordinate_system RelativeCS1 = origin=(-21mm, -15mm, 0mm) x=(1mm, 0mm, 0mm) y=(0mm, 1mm, 0mm)
  u141_0711_201_1 = component(u141_0711_201, 3D_Component_File_Path=/home/ubuntu/Ansoft/repo/components/u141_0711_201.a3dcomp, Rin="(0.05/2) in")
  shell, pin [pec] = part_of(u141_0711_201_1) in RelativeCS1
  dielectric [Teflon (tm)] = part_of(u141_0711_201_1) in RelativeCS1
  port [vacuum] = part_of(u141_0711_201_1) in RelativeCS1
  cap [pec] = part_of(u141_0711_201_1) in RelativeCS1
  u141_0711_201_1.mirror(MirrorBaseX=0mm MirrorBaseY=0mm MirrorBaseZ=0mm MirrorNormalX=0mm MirrorNormalY=0mm MirrorNormalZ=1mm) in RelativeCS1
  RadiatingSurface [vacuum] = region(absolute_offset=pad on all sides) in RelativeCS1
boundaries and excitations:
  film_Imp: Impedance Objects=film Resistance=R0 Reactance=0
  Open1: Radiation Objects=RadiatingSurface
  u141_0711_201_1_pin_T1: Terminal port=u141_0711_201_1_1 Faces=pin.face(at (-21, -15, -8.8392)) TerminalResistance=50ohm
  u141_0711_201_1_1: Wave Port Faces=port.face(at (-21, -15, -8.8392)) WavePortType=Terminal NumModes=1
mesh:
  initial mesh: MeshMethod=AnsoftClassic
setups:
  Setup1: HfssDriven Frequency=2.42GHz MaxDeltaS=0.01 MaximumPasses=30 MinimumPasses=1 MinimumConvergedPasses=2 PercentRefinement=15 BasisOrder=-1 Target=0.666667 PortAccuracy=0.5 DrivenSolverType="Direct Solver"
    sweep Sweep: 1.8GHz to 2.8GHz, 51 points; Type=Discrete SaveFields
source amplitudes:
  u141_0711_201_1_1:1: 1V 0deg
radiation setups:
  3D: Infinite Sphere Theta=0deg..180deg step 2deg Phi=-180deg..180deg step 2deg CoordSystem=RelativeCS1
  Elevation: Infinite Sphere Theta=-180deg..180deg step 1deg Phi=0deg..90deg step 90deg CoordSystem=RelativeCS1
  Azimuth: Infinite Sphere Theta=90deg..90deg step 0deg Phi=-180deg..180deg step 1deg CoordSystem=RelativeCS1
reports:
  Terminal S Parameter Plot 1: dB(St(u141_0711_201_1_pin_T1,u141_0711_201_1_pin_T1)) vs Freq on Setup1 : Sweep; markers MY1 at y=-15
  Antenna Params Plot 1: SystemEfficiency vs Freq on Setup1 : Sweep; markers MX1 at x=2.42e+09
  Gain Plot 1: dB(GainLHCP), dB(GainRHCP) vs Theta on Setup1 : LastAdaptive, 3D [Phi=-180deg,0deg Freq=2.42GHz]
